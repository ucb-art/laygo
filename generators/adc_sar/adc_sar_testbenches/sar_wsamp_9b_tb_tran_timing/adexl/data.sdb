ADE simulation setup
Run mode: Single Run, Sweeps and Corners
Tests:
  adc_sar_testbenches:sar_9b_tb_tran:1: adc_sar_testbenches/sar_wsamp_9b_tb_tran_timing_rcx/config_netlist, simulator spectre
Global variables:
  pdelay = 1n
  pper = 1n
  pskew_rst = 0
  pvdd = 0.8
  pvicm = 150m
  pvidm = 150m
  pvref0 = 0.0
  pvref1 = 0.15
  pvref2 = 0.3
  vdd = 0.8
