`include "discipline.h"
`include "constants.h"

// $Date: 1997/08/28 05:54:36 $
// $Revision: 1.1 $
//
//

//--------------------
// dac_9bit_ideal
//
// -  9 bit digital analog converter
//
// vd0..vd9:	data inputs [V,A]
// vout:	[V,A]
//
// INSTANCE parameters
//    vref   = reference voltage that conversion is with respect to [V]
//    vtrans = transition voltage between logic high and low [V]
//    tdel,trise,tfall = {usual} [s]
//
// MODEL parameters
//    {none}

module dac_9bit_ideal (vd8, vd7, vd6, vd5, vd4, vd3, vd2, vd1, vd0, vout, dout);
electrical vd8, vd7, vd6, vd5, vd4, vd3, vd2, vd1, vd0, vout, dout;
parameter real vref  = 1 from [0:inf);
parameter real trise = 20p from [0:inf);
parameter real tfall = 20p from [0:inf);
parameter real tdel  = 10p from [0:inf);
parameter real vtrans  = 0.45;

    real out_scaled; // output scaled as fraction of 256

    analog begin
		out_scaled = 0;
		out_scaled = out_scaled + ((V(vd8) > vtrans) ? 256 : 0);
		out_scaled = out_scaled + ((V(vd7) > vtrans) ? 128 : 0);
		out_scaled = out_scaled + ((V(vd6) > vtrans) ? 64 : 0);
		out_scaled = out_scaled + ((V(vd5) > vtrans) ? 32 : 0);
		out_scaled = out_scaled + ((V(vd4) > vtrans) ? 16 : 0);
		out_scaled = out_scaled + ((V(vd3) > vtrans) ? 8 : 0);
		out_scaled = out_scaled + ((V(vd2) > vtrans) ? 4 : 0);
		out_scaled = out_scaled + ((V(vd1) > vtrans) ? 2 : 0);
		out_scaled = out_scaled + ((V(vd0) > vtrans) ? 1 : 0);
		V(dout) <+ transition( out_scaled, tdel, trise, tfall );
		V(vout) <+ transition( vref*out_scaled/512, tdel, trise, tfall );
    end
endmodule
