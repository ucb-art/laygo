ADE simulation setup
Run mode: Single Run, Sweeps and Corners
Tests:
  adc_sar_templates:sarsamp_tb_ac:1: adc_sar_templates/sarsamp_tb_ac/schematic, simulator spectre
Global variables:
  cckload = 30f
  cload = 30f
  vck = 0.8
  vcm = 0.15
  vdd = 0.8
  fmax = 500G
