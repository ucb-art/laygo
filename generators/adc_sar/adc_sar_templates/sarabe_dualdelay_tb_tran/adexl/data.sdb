ADE simulation setup
Run mode: Single Run, Sweeps and Corners
Tests:
  adc_sar_templates:sarabe_dualdelay_tb_tran:1: adc_sar_templates/sarabe_dualdelay_tb_tran/schematic, simulator spectre
Global variables:
  trf = 10p
  vdd = 0.8
  cload = 6f
