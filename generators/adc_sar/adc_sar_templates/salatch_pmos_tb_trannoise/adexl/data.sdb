ADE simulation setup
Run mode: Single Run, Sweeps and Corners
Tests:
  adc_sar_templates:salatch_pmos_tb_trannoise:1: adc_sar_templates/salatch_pmos_tb_trannoise/schematic, simulator spectre
Global variables:
  vdd = 0.8
  vamp = 500u
  vcm = 0.2
  vos = 0
  voscm = 600m
  cload = 20f
  csaload = 10f
  cint = 10f
  ctail = 10f
  costail = 10f
  tper = 1n
  tr = 20p
  tsim = 2.5n
  tstep = 1p
