ADE simulation setup
Run mode: Single Run, Sweeps and Corners
Tests:
  adc_sar_templates:capdrv_nsw_tb_tran:1: adc_sar_templates/capdrv_nsw_array_tb_tran/schematic, simulator spectre
Global variables:
  trf = 20p
  vdd = 0.8
  vref0 = 0.3
  vref1 = 0.14
  vref2 = 0.3
