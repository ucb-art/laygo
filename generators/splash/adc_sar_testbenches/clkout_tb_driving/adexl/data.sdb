ADE simulation setup
Run mode: Single Run, Sweeps and Corners
Tests:
  adc_sar_testbenches:clkout_tb_driving:1: adc_sar_testbenches/clkout_tb_driving/config, simulator spectre
Global variables:
  duty = 0.125
  tper = 800p
  tr = 20p
  vdd = 800m
  cl = {Inclusion List}0.3f 0.44f 0.75f 1.37f 2.6f 5.06f 9.99f 19.85f{Inclusion List}
Corners (nominal off):
  model folders: /tools/tstech16/CLN16FFC/PDK/models
  tt: temperature=25; vdd=0.8; toplevel.scs[top_tt]
  ssgnp072v125c: temperature=125; vdd=0.72; toplevel.scs[top_ss]
  ssgnp072v0c: temperature=0; vdd=0.72; toplevel.scs[top_ss]
  ffgnp0p88v125c: temperature=125; vdd=0.88; toplevel.scs[top_ff]
  ffgnp88v0c: temperature=0; vdd=0.88; toplevel.scs[top_ff]
