ADE simulation setup
Run mode: Single Run, Sweeps and Corners
Tests:
  adc_sar_testbenches:sar_wsamp_9b_tb_tran_static:1: adc_sar_testbenches/tisar_static_test/schematic, simulator spectre
    Outputs: /ckin<3>; /SARCLK; /SARCLKB; /inp<3>; /inn<3>; vout; adccode; /IDEALDACOUT; /ADCCODE
Global variables:
  vdd = 1000m
  pdelay = 800p/8
  pper = {Inclusion List}2.5n{Inclusion List}
  pskew_rst = 0
  pvicm = 150m
  pvidm = {From/To}Linear:-290m:1m:290m{From/To}
  pvref0 = 0.0
  pvref1 = 150m
  pvref2 = 300m
  duty = 2
