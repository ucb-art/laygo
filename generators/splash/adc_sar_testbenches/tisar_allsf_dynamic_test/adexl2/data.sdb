ADE simulation setup
Run mode: Single Run, Sweeps and Corners
Tests:
  adc_sar_testbenches:sar_wsamp_9b_tb_tran_static:1 (off): adc_sar_testbenches/tisar_static_test/schematic, simulator spectre
    Outputs: /ckin<3>; /SARCLK; /SARCLKB; /inp<3>; /inn<3>; vout; adccode; /IDEALDACOUT; /ADCCODE
  adc_sar_testbenches:tisar_dynamic_test:1: adc_sar_testbenches/tisar_allsf_dynamic_test/config, simulator spectre
    Outputs: sample(VT("/IDEALDACOUT") 9e-09 2.062e-06 "linear" 2e-09)
  adc_sar_testbenches:tisar_dynamic_test:2 (off): adc_sar_testbenches/tisar_sf_dynamic_test/config, simulator spectre
    Outputs: sample(VT("/IDEALDACOUT") 3e-09 5.126e-06 "linear" 2.5e-09); sample(VT("/IDEALDACOUT") 5.5e-09 5.126e-06 "linear" 2.5e-09); sample(VT("/IDEALDACOUT") 1.05e-08 5.131e-06 "linear" 2.5e-09); sample(VT("/IDEALDACOUT") 1.05e-08 5.136e-06 "linear" 2.5e-09); /inp<3>; /inn<3>
Global variables:
  vdd = 1200m
  pdelay = 800p/8
  pper = 2n
  pskew_rst = 0
  pvicm = 150m
  pvidm = 250m
  pvref0 = 0.0
  pvref1 = 150m
  pvref2 = 300m
  duty = 30
  fin = 7812.988281Meg
  vamplitude = 500m
  vb_bot_sw = 0
  vb_top_sw = 0
  voffset = 0
