ADE simulation setup
Run mode: Single Run, Sweeps and Corners
Tests:
  adc_sar_testbenches:sampler_nmos_tb_ac:1: adc_sar_testbenches/sampler_nmos_tb_noise/schematic, simulator spectre
    Outputs: von
Global variables:
  vidm_ac = 1
  vidm_dc = 0
  vdd = 0.8
  vicm = 0.4
