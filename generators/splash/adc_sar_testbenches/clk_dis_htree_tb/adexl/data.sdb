ADE simulation setup
Run mode: Single Run, Sweeps and Corners
Tests:
  adc_sar_testbenches:clk_dis_htree_tb:1: adc_sar_testbenches/clk_dis_htree_tb/schematic, simulator spectre
Global variables:
  pper = 200p
  pslew = 10p
  vdd = 1.2
