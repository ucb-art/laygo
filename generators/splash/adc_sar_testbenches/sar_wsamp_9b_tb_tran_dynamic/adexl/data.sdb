ADE simulation setup
Run mode: Single Run, Sweeps and Corners
Tests:
  adc_sar_testbenches:sar_wsamp_9b_tb_tran_dynamic:1: adc_sar_testbenches/sar_wsamp_9b_tb_tran_dynamic/config, simulator spectre
Global variables:
  vdd = 1.2
  fin = 22.94921875Meg
  pper = 2n
  pskew_rst = 0
  pvicm = 150m
  pvidm = 280m
  pvref0 = 0
  pvref1 = 150m
  pvref2 = 300m
  duty = 1
  vamplitude = 500m
  vb_bot_sw = 0
  vb_top_sw = 0
  voffset = 0
