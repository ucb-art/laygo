ADE simulation setup
Run mode: Single Run, Sweeps and Corners
Tests:
  adc_sar_testbenches:ti_test:1: adc_sar_testbenches/ti_test/schematic, simulator spectre
    Outputs: ""; "/a"; "/b"; "/c<1>"; /an; /bn; /cn<1>; "/c<0>"; /cn<0>; /a; /b; /c<1>; /c<0>
Global variables:
  pper = 0.4n
  pvicm = 200m
  pvidm = 100m
  vdd = 0.8
  duty = {From/To}Linear:2:1:3{From/To}
