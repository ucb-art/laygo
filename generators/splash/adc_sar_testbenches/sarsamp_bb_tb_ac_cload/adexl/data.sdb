ADE simulation setup
Run mode: Single Run, Sweeps and Corners
Tests:
  adc_sar_testbenches:sampler_nmos_tb_ac:1: adc_sar_testbenches/sarsamp_bb_tb_ac_cload/schematic, simulator spectre
    Outputs: bw
Global variables:
  vidm_ac = 1
  vidm_dc = 0
  vdd = 1.0
  vicm = {Inclusion List}0, 0.2, 0.4, 0.6{Inclusion List}
  cload = 128f
  vbb = {From/To}Linear:0:0.1:1{From/To}
