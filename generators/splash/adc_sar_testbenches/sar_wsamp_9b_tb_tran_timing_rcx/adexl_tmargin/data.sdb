ADE simulation setup
Run mode: Single Run, Sweeps and Corners
Tests:
  adc_sar_testbenches:sar_wsamp_9b_tb_tran_timing_rcx:1: adc_sar_testbenches/sar_wsamp_9b_tb_tran_timing_rcx/config, simulator spectre
    Outputs: /CLKO; "/XDUT0/ISAR0/IABE0/RETI(0)"; "/XDUT0/ISAR0|IABE0|RETI(0)"; "/XDUT0/ISAR0/IABE0|RETI(0)"; /XDUT0/ISAR0/IABE0|RETI(0); "/XDUT0/ISAR0/IABE0/RETI<0>"; /XDUT0/ISAR0/IABE0/RETI<0>; tmargin_9bit; tmargin_8bit; tmargin_7bit; tmargin_6bit; /XDUT0/ISAR0/IABE0/ISARLOGIC0/ZP0<0>; /SB<0>; /SARCLK; f; /ICLK; /XDUT0/ISAR0/IABE0/RETI<8>; /XDUT0/ISAR0/IABE0/RETI<4>; /SB<8>; /SB<7>; /DONE; /SAOP; /SAOM; /SARCLKB; /UP; /ZM<2>; IDC("/I4/gnd!"); IDC("/VVDD/PLUS"); pavg(IDC("/VVDD/PLUS") 0 pper nil 1); pavg("/VVDD/PLUS" 0 pper nil 1); pavg(IDC("/VVDD/PLUS") 0 (VAL "pper") nil 1); pavg(IDC("/VVDD/PLUS") 0 VAR("pper") nil 1); /SAMPP
Global variables:
  vdd = {Inclusion List}1000m{Inclusion List}
  pdelay = 800p/8
  pper = {Inclusion List}10n{Inclusion List}
  pskew_rst = 0
  pvdd = 1
  pvicm = 150m
  pvidm = {Inclusion List}-100m{Inclusion List}
  pvref0 = 0.0
  pvref1 = 150m
  pvref2 = 300m
Corners:
  model folders: /tools/tstech16/CLN16FFC/PDK/models
  tt (off): temperature=25; vdd=0.9; toplevel.scs[top_tt]
  ssgnp072v125c (off): temperature=125; vdd=0.72; toplevel.scs[top_ss]
  ssgnp072v0c (off): temperature=0; vdd=0.72; toplevel.scs[top_ss]
  ffgnp0p88v125c (off): temperature=125; vdd=0.9; toplevel.scs[top_ff]
  ffgnp88v0c (off): temperature=0; vdd=0.9; toplevel.scs[top_ff]
  ssgnp09v125c (off): temperature=125; vdd=0.9; toplevel.scs[top_ss_gnp]
