ADE simulation setup
Run mode: Single Run, Sweeps and Corners
Tests:
  adc_sar_testbenches:sar_wsamp_9b_tb_tran_static:1: adc_sar_testbenches/sar_wsamp_9b_tb_tran_static/config, simulator spectre
Global variables:
  vdd = 1000m
  pdelay = 800p/8
  pper = {Inclusion List}3n{Inclusion List}
  pskew_rst = 0
  pvicm = 150m
  pvidm = {From/To}Linear:-240m:60m:240m{From/To}
  pvref0 = 0.0
  pvref1 = 150m
  pvref2 = 300m
