ADE simulation setup
Run mode: Single Run, Sweeps and Corners
Tests:
  adc_sar_testbenches:capdac_8b_tb_tran:1: adc_sar_testbenches/capdac_8b_tb_tran/schematic, simulator spectre
Global variables:
  pper = 1n
  pvcm = 0.15
  pvh = 0.3
  pvl = 0
