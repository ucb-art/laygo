ADE simulation setup
Run mode: Single Run, Sweeps and Corners
Tests:
  adc_sar_testbenches:sampler_nmos_tb_ac:1: adc_sar_testbenches/sampler_nmos_tb_ac_cload/schematic, simulator spectre
Global variables:
  vidm_ac = 1
  vidm_dc = 0
  vdd = 0.8
  vicm = 0.4
  cload = 128f
