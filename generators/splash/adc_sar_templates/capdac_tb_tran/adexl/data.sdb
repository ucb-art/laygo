ADE simulation setup
Run mode: Single Run, Sweeps and Corners
Tests:
  adc_sar_templates:capdac_tb_tran:1: adc_sar_templates/capdac_tb_tran/schematic, simulator spectre
Global variables:
  tsim = 400n
  vcm = 150m
  pper = 1n
  pvcm = 0.15
  pvh = 0.3
  pvl = 0
