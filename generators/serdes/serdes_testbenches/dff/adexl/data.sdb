ADE simulation setup
Run mode: Single Run, Sweeps and Corners
Tests:
  serdes_testbenches:dff:1: serdes_testbenches/dff/config, simulator spectre
Global variables:
  delay = {Exclusion List}0{Exclusion List}{From/To}Linear:-20p:1p:20p{From/To}
  vdd = 0.72
